// VerilogA for VerilogA, Data_Voltage, veriloga

`include "constants.vams"
`include "disciplines.vams"

module Data_Voltage;

endmodule

// Data to pwl conversion

module pwl(in, VDDI, Vwr, Vwl, Vs , Vwl1, Vwg, Vwg1, Vsl, Vsl1);
  input in,VDDI;               // Declare input signal
  output Vwr, Vwl, Vs , Vwl1, Vwg, Vwg1, Vsl, Vsl1;             // Declare output signal
  electrical in, VDDI, Vwr, Vwl, Vs , Vwl1, Vwg, Vwg1, Vsl, Vsl1;     // Declare electrical nodes for input and output
  electrical p[0:7], n[0:7];        // Declare internal electrical nodes

  // Time and voltage pairs for PWL signal
  parameter real Vi0[0:1] = {0, 2.5} ;         // Vs Voltage levels
  parameter real Vi1[0:3] = {2.5, 0, 0, 2.5};         //Vwr  Voltage levels
  parameter real Vi2[0:1] = {0, 0};         //Vwg  Voltage levels
  parameter real Vi3[0:4] = {0, 0, 2.5, 2.5, 0};         //Vwg1 Voltage levels
  parameter real Vi4[0:5] = {0, 1, 1, 0, 0, 1};         //Vwl Voltage levels
  parameter real Vi5[0:5] = {0, 1, 1, 2.5, 2.5, 1};         //Vwl1 Voltage levels
  parameter real Vi6[0:1] = {0, 0};         //Sl Voltage levels
  parameter real Vi7[0:4] = {0, 0, 2.5, 2.5, 0};         //Sl1 Voltage levels
 // parameter real T[0:5] = {0.0, 0.000000001, 0.000002, 0.000002001, 0.000004, 0.000004001}; // Time points
  parameter real T1[0:5] = {0.0, 0.001e-6, 2e-6, 2.001e-6, 4e-6, 4.001e-6}; // Time points
  parameter real T2[0:4] = {0.0, 2e-6, 2.001e-6, 4e-6, 4.001e-6}; // Time points
  parameter integer size = 6;                          // Number of time points

  real  V_wr, V_wl, V_s , V_wl1, V_wg, V_wg1, V_sl, V_sl1;         // Declare internal voltage variable
    real vin_voltage;   // Declare voltage at input node
    integer i;          // Declare loop variable
//	integer in, vin_voltage;
  analog begin
 //   real v_out;         // Declare internal voltage variable
 //   integer i;          // Declare loop variable
//	integer vin_voltage;
	if (V(VDDI)>1) begin
    // Default value before the first time point
    V_s = Vi0[0];
    V_wr = Vi1[0];
    V_wg = Vi2[0];
    V_wg1 = Vi3[0];
    V_wl = Vi4[0];
    V_wl1 = Vi5[0];
    V_sl = Vi6[0];
    V_sl1 = Vi7[0];

	// Access the voltage at the input node
    vin_voltage = V(in);  // Correctly accessing voltage at 'in'

    // Check if the input signal is high (in = 1)
    if (vin_voltage > 0.5) begin
     // Linear interpolation for Vs
      for (i = 0; i < size - 5; i = i + 1) begin
        if ($abstime >= T1[i] && $abstime < T1[i + 1]) begin
          V_s = Vi0[i] + (Vi0[i + 1] - Vi0[i]) * (($abstime - T1[i]) / (T1[i + 1] - T1[i]));
        end
      end
      if ($abstime >= T1[size - 5]) begin  V_s = Vi0[size - 5]; end

     // Linear interpolation for Vwr
      for (i = 0; i < size - 3; i = i + 1) begin
        if ($abstime >= T1[i] && $abstime < T1[i + 1]) begin
        V_wr = Vi1[i] + (Vi1[i + 1] - Vi1[i]) * (($abstime - T1[i]) / (T1[i + 1] - T1[i]));
        end
      end
      if ($abstime >= T1[size - 3]) begin V_wr = Vi1[size - 3]; end

	// Linear interpolation for Vwg
      for (i = 0; i < size - 5; i = i + 1) begin
        if ($abstime >= T1[i] && $abstime < T1[i + 1]) begin
          V_wg = Vi2[i] + (Vi2[i + 1] - Vi2[i]) * (($abstime - T1[i]) / (T1[i + 1] - T1[i]));
        end
      end

     // Linear interpolation for Vwg1
      for (i = 0; i < size - 2; i = i + 1) begin
        if ($abstime >= T2[i] && $abstime < T2[i + 1]) begin
          V_wg1 = Vi3[i] + (Vi3[i + 1] - Vi3[i]) * (($abstime - T2[i]) / (T2[i + 1] - T2[i]));
        end
      end
      if ($abstime >= T2[size - 2]) begin  V_wg1 = Vi3[size - 2]; end

      // Linear interpolation for Vwl
      for (i = 0; i < size - 1; i = i + 1) begin
        if ($abstime >= T1[i] && $abstime < T1[i + 1]) begin
          V_wl = Vi4[i] + (Vi4[i + 1] - Vi4[i]) * (($abstime - T1[i]) / (T1[i + 1] - T1[i]));
        end
      end
      if ($abstime >= T1[size - 1]) begin V_wl = Vi4[size - 1]; end

      // Linear interpolation for Vwl1
      for (i = 0; i < size - 1; i = i + 1) begin
        if ($abstime >= T1[i] && $abstime < T1[i + 1]) begin
          V_wl1 = Vi5[i] + (Vi5[i + 1] - Vi5[i]) * (($abstime - T1[i]) / (T1[i + 1] - T1[i]));
        end
      end
      if ($abstime >= T1[size - 1]) begin  V_wl1 = Vi5[size - 1]; end

	// Linear interpolation for Vs
      for (i = 0; i < size - 5; i = i + 1) begin
        if ($abstime >= T1[i] && $abstime < T1[i + 1]) begin
          V_sl = Vi6[i] + (Vi6[i + 1] - Vi6[i]) * (($abstime - T1[i]) / (T1[i + 1] - T1[i]));
        end
      end

     // Linear interpolation for Vsl1
      for (i = 0; i < size - 2; i = i + 1) begin
        if ($abstime >= T2[i] && $abstime < T2[i + 1]) begin
          V_sl1 = Vi7[i] + (Vi7[i + 1] - Vi7[i]) * (($abstime - T2[i]) / (T2[i + 1] - T2[i]));
        end
      end
      // Hold the voltage after the last time point
      if ($abstime >= T2[size - 2]) begin V_sl1 = Vi7[size - 2]; end
      if ($abstime >= T1[1])
		 begin  V_wg = Vi2[1];
				V_sl = Vi6[1];
		 end

      // Apply the calculated voltage to the terminals p and n
      V(p[0], n[0]) <+ V_s;
      V(p[1], n[1]) <+ V_wr;
      V(p[2], n[2]) <+ V_wg;
      V(p[3], n[3]) <+ V_wg1;
      V(p[4], n[4]) <+ V_wl;
      V(p[5], n[5]) <+ V_wl1;
      V(p[6], n[6]) <+ V_sl;
      V(p[7], n[7]) <+ V_sl1;

    end
    else begin
      // If the input signal is low (in = 0), set output to 0V

           // Linear interpolation for Vs
      for (i = 0; i < size - 5; i = i + 1) begin
        if ($abstime >= T1[i] && $abstime < T1[i + 1]) begin
          V_s = Vi0[i] + (Vi0[i + 1] - Vi0[i]) * (($abstime - T1[i]) / (T1[i + 1] - T1[i]));
        end
      end
      if ($abstime >= T1[size - 5]) begin  V_s = Vi0[size - 5]; end

     // Linear interpolation for Vwr
      for (i = 0; i < size - 3; i = i + 1) begin
        if ($abstime >= T1[i] && $abstime < T1[i + 1]) begin
        V_wr = Vi1[i] + (Vi1[i + 1] - Vi1[i]) * (($abstime - T1[i]) / (T1[i + 1] - T1[i]));
        end
      end
      if ($abstime >= T1[size - 3]) begin V_wr = Vi1[size - 3]; end

	// Linear interpolation for Vwg1
      for (i = 0; i < size - 5; i = i + 1) begin
        if ($abstime >= T1[i] && $abstime < T1[i + 1]) begin
          V_wg1 = Vi2[i] + (Vi2[i + 1] - Vi2[i]) * (($abstime - T1[i]) / (T1[i + 1] - T1[i]));
        end
      end

     // Linear interpolation for Vwg1
      for (i = 0; i < size - 2; i = i + 1) begin
        if ($abstime >= T2[i] && $abstime < T2[i + 1]) begin
          V_wg = Vi3[i] + (Vi3[i + 1] - Vi3[i]) * (($abstime - T2[i]) / (T2[i + 1] - T2[i]));
        end
      end
      if ($abstime >= T2[size - 2]) begin  V_wg = Vi3[size - 2]; end

      // Linear interpolation for Vwl
      for (i = 0; i < size - 1; i = i + 1) begin
        if ($abstime >= T1[i] && $abstime < T1[i + 1]) begin
          V_wl1 = Vi4[i] + (Vi4[i + 1] - Vi4[i]) * (($abstime - T1[i]) / (T1[i + 1] - T1[i]));
        end
      end
      if ($abstime >= T1[size - 1]) begin V_wl = Vi4[size - 1]; end

      // Linear interpolation for Vwl1
      for (i = 0; i < size - 1; i = i + 1) begin
        if ($abstime >= T1[i] && $abstime < T1[i + 1]) begin
          V_wl = Vi5[i] + (Vi5[i + 1] - Vi5[i]) * (($abstime - T1[i]) / (T1[i + 1] - T1[i]));
        end
      end
      if ($abstime >= T1[size - 1]) begin  V_wl1 = Vi5[size - 1]; end

	// Linear interpolation for Vs
      for (i = 0; i < size - 5; i = i + 1) begin
        if ($abstime >= T1[i] && $abstime < T1[i + 1]) begin
          V_sl1 = Vi6[i] + (Vi6[i + 1] - Vi6[i]) * (($abstime - T1[i]) / (T1[i + 1] - T1[i]));
        end
      end

     // Linear interpolation for Vsl1
      for (i = 0; i < size - 2; i = i + 1) begin
        if ($abstime >= T2[i] && $abstime < T2[i + 1]) begin
          V_sl = Vi7[i] + (Vi7[i + 1] - Vi7[i]) * (($abstime - T2[i]) / (T2[i + 1] - T2[i]));
        end
      end
      // Hold the voltage after the last time point
      if ($abstime >= T2[size - 2]) begin V_sl = Vi7[size - 2]; end
      if ($abstime >= T1[1])
		 begin  V_wg1 = Vi2[1];
				V_sl1 = Vi6[1];
		 end

      // Apply the calculated voltage to the terminals p and n
      V(p[0], n[0]) <+ V_s;
      V(p[1], n[1]) <+ V_wr;
      V(p[2], n[2]) <+ V_wg;
      V(p[3], n[3]) <+ V_wg1;
      V(p[4], n[4]) <+ V_wl;
      V(p[5], n[5]) <+ V_wl1;
      V(p[6], n[6]) <+ V_sl;
      V(p[7], n[7]) <+ V_sl1;
    end

	 // Output the same voltage to the output node
      V(Vs) <+  V(p[0], n[0]);
      V(Vwr) <+  V(p[1], n[1]);
      V(Vwg) <+  V(p[2], n[2]);
      V(Vwg1) <+  V(p[3], n[3]);
      V(Vwl) <+  V(p[4], n[4]);
      V(Vwl1) <+  V(p[5], n[5]);
      V(Vsl) <+  V(p[6], n[6]);
      V(Vsl1) <+  V(p[7], n[7]);
  end
end
endmodule

module data_read( VDDI, D_p, D_n);
input VDDI;
electrical VDDI;
output [1023:0] D_p, D_n;
electrical [1023:0] D_p, D_n;

 integer file, status, index;
  integer binary_data_array[0:15]; // Array to store up to 16 binary numbers
  integer binary_data;             // Variable to hold each binary line
  integer is_file_open;

  analog begin

	if (V(VDDI)>1) begin
		for (index = 0; index < 16; index = index + 1) begin
        binary_data_array[index] = 0;
      end

      // Open the file in read mode
     	 file = $fopen("/home/saik/worklib_sky/reram/sai/data_read1/data.txt", "r");
      	if (file == 0) begin
        		$strobe("Error: Could not open file data.txt.");
       		 is_file_open = 0; // Set the flag to indicate failure
      	end else begin
        		is_file_open = 1; // Set the flag to indicate success
     	end

      	if (is_file_open) begin
        		index = 0;
       		while (!$feof(file) && index < 16) begin
          		status = $fscanf(file, "%b\n", binary_data);
          		if (status > 0) begin
            			binary_data_array[index] = binary_data;
           			 $strobe("Stored binary_data_array[%0d] = %b", index, binary_data);
           			 index = index + 1;
         		end else begin
            			$strobe("Error reading binary data");
           			break;
          		end
        		end
        $fclose(file);
        $strobe("Finished reading data.");
      	end
	//	genvar i;
        generate i (1023,0) begin
			 D_p[i] = (binary_data_array[i] >> 1) & 1; // Assign bits to D_p
              D_n[i] = (binary_data_array[i] >> 0) & 1; // Assign bits to D_n
			end
    //        for (i = 0; i < 1024; i = i + 1) begin : assign_bits
    //            D_p[i] = (binary_data_array[i] >> 1) & 1; // Assign bits to D_p
    ///            D_n[i] = (binary_data_array[i] >> 0) & 1; // Assign bits to D_n
     //       end
      //  endgenerate

	//	D_p[0]= (binary_data_array[1] >> 1) & 1;
	end

end

endmodule
