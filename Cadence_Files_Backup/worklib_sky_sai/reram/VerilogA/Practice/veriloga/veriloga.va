// VerilogA for VerilogA, Practice, veriloga

`include "constants.vams"
`include "disciplines.vams"

module pwl(in, Vwr, Vwl, Vs , Vwl1, Vwg, Vwg1, Vsl, Vsl1);
  input in;               // Declare input signal
  output Vwr, Vwl, Vs , Vwl1, Vwg, Vwg1, Vsl, Vsl1;             // Declare output signal
  electrical in, Vwr, Vwl, Vs , Vwl1, Vwg, Vwg1, Vsl, Vsl1;     // Declare electrical nodes for input and output
  electrical p[0:7], n[0:7];        // Declare internal electrical nodes

  // Time and voltage pairs for PWL signal
  parameter real Vi0[0:1] = {0, 2.5} ;         // Vs Voltage levels
  parameter real Vi1[0:3] = {2.5, 0, 0, 2.5};         //Vwr  Voltage levels
  parameter real Vi2[0:1] = {0, 0};         //Vwg  Voltage levels
  parameter real Vi3[0:4] = {0, 0, 2.5, 2.5, 0};         //Vwg1 Voltage levels
  parameter real Vi4[0:5] = {0, 1, 1, 0, 0, 1};         //Vwl Voltage levels
  parameter real Vi5[0:5] = {0, 1, 1, 2.5, 2.5, 1};         //Vwl1 Voltage levels
  parameter real Vi6[0:1] = {0, 0};         //Sl Voltage levels
  parameter real Vi7[0:4] = {0, 0, 2.5, 2.5, 0};         //Sl1 Voltage levels
 // parameter real T[0:5] = {0.0, 0.000000001, 0.000002, 0.000002001, 0.000004, 0.000004001}; // Time points
  parameter real T1[0:5] = {0.0, 0.001e-6, 2e-6, 2.001e-6, 4e-6, 4.001e-6}; // Time points
  parameter real T2[0:4] = {0.0, 2e-6, 2.001e-6, 4e-6, 4.001e-6}; // Time points
  parameter integer size = 6;                          // Number of time points

  real  V_wr, V_wl, V_s , V_wl1, V_wg, V_wg1, V_sl, V_sl1;         // Declare internal voltage variable
    real vin_voltage;   // Declare voltage at input node
    integer i;          // Declare loop variable
//	integer in, vin_voltage;
  analog begin
 //   real v_out;         // Declare internal voltage variable
 //   integer i;          // Declare loop variable
//	integer vin_voltage;

    // Default value before the first time point
    V_s = Vi0[0];
    V_wr = Vi1[0];
    V_wg = Vi2[0];
    V_wg1 = Vi3[0];
    V_wl = Vi4[0];
    V_wl1 = Vi5[0];
    V_sl = Vi6[0];
    V_sl1 = Vi7[0];

	// Access the voltage at the input node
    vin_voltage = V(in);  // Correctly accessing voltage at 'in'

    // Check if the input signal is high (in = 1)
    if (vin_voltage > 0.5) begin
     // Linear interpolation for Vs
      for (i = 0; i < size - 5; i = i + 1) begin
        if ($abstime >= T1[i] && $abstime < T1[i + 1]) begin
          V_s = Vi0[i] + (Vi0[i + 1] - Vi0[i]) * (($abstime - T1[i]) / (T1[i + 1] - T1[i]));
        end
      end
      if ($abstime >= T1[size - 5]) begin  V_s = Vi0[size - 5]; end

     // Linear interpolation for Vwr
      for (i = 0; i < size - 3; i = i + 1) begin
        if ($abstime >= T1[i] && $abstime < T1[i + 1]) begin
        V_wr = Vi1[i] + (Vi1[i + 1] - Vi1[i]) * (($abstime - T1[i]) / (T1[i + 1] - T1[i]));
        end
      end
      if ($abstime >= T1[size - 3]) begin V_wr = Vi1[size - 3]; end

	// Linear interpolation for Vwg
      for (i = 0; i < size - 5; i = i + 1) begin
        if ($abstime >= T1[i] && $abstime < T1[i + 1]) begin
          V_wg = Vi2[i] + (Vi2[i + 1] - Vi2[i]) * (($abstime - T1[i]) / (T1[i + 1] - T1[i]));
        end
      end

     // Linear interpolation for Vwg1
      for (i = 0; i < size - 2; i = i + 1) begin
        if ($abstime >= T2[i] && $abstime < T2[i + 1]) begin
          V_wg1 = Vi3[i] + (Vi3[i + 1] - Vi3[i]) * (($abstime - T2[i]) / (T2[i + 1] - T2[i]));
        end
      end
      if ($abstime >= T2[size - 2]) begin  V_wg1 = Vi3[size - 2]; end

      // Linear interpolation for Vwl
      for (i = 0; i < size - 1; i = i + 1) begin
        if ($abstime >= T1[i] && $abstime < T1[i + 1]) begin
          V_wl = Vi4[i] + (Vi4[i + 1] - Vi4[i]) * (($abstime - T1[i]) / (T1[i + 1] - T1[i]));
        end
      end
      if ($abstime >= T1[size - 1]) begin V_wl = Vi4[size - 1]; end

      // Linear interpolation for Vwl1
      for (i = 0; i < size - 1; i = i + 1) begin
        if ($abstime >= T1[i] && $abstime < T1[i + 1]) begin
          V_wl1 = Vi5[i] + (Vi5[i + 1] - Vi5[i]) * (($abstime - T1[i]) / (T1[i + 1] - T1[i]));
        end
      end
      if ($abstime >= T1[size - 1]) begin  V_wl1 = Vi5[size - 1]; end

	// Linear interpolation for Vs
      for (i = 0; i < size - 5; i = i + 1) begin
        if ($abstime >= T1[i] && $abstime < T1[i + 1]) begin
          V_sl = Vi6[i] + (Vi6[i + 1] - Vi6[i]) * (($abstime - T1[i]) / (T1[i + 1] - T1[i]));
        end
      end

     // Linear interpolation for Vsl1
      for (i = 0; i < size - 2; i = i + 1) begin
        if ($abstime >= T2[i] && $abstime < T2[i + 1]) begin
          V_sl1 = Vi7[i] + (Vi7[i + 1] - Vi7[i]) * (($abstime - T2[i]) / (T2[i + 1] - T2[i]));
        end
      end
      // Hold the voltage after the last time point
      if ($abstime >= T2[size - 2]) begin V_sl1 = Vi7[size - 2]; end
      if ($abstime >= T1[1])
		 begin  V_wg = Vi2[1];
				V_sl = Vi6[1];
		 end

      // Apply the calculated voltage to the terminals p and n
      V(p[0], n[0]) <+ V_s;
      V(p[1], n[1]) <+ V_wr;
      V(p[2], n[2]) <+ V_wg;
      V(p[3], n[3]) <+ V_wg1;
      V(p[4], n[4]) <+ V_wl;
      V(p[5], n[5]) <+ V_wl1;
      V(p[6], n[6]) <+ V_sl;
      V(p[7], n[7]) <+ V_sl1;

    end
    else begin
      // If the input signal is low (in = 0), set output to 0V

           // Linear interpolation for Vs
      for (i = 0; i < size - 5; i = i + 1) begin
        if ($abstime >= T1[i] && $abstime < T1[i + 1]) begin
          V_s = Vi0[i] + (Vi0[i + 1] - Vi0[i]) * (($abstime - T1[i]) / (T1[i + 1] - T1[i]));
        end
      end
      if ($abstime >= T1[size - 5]) begin  V_s = Vi0[size - 5]; end

     // Linear interpolation for Vwr
      for (i = 0; i < size - 3; i = i + 1) begin
        if ($abstime >= T1[i] && $abstime < T1[i + 1]) begin
        V_wr = Vi1[i] + (Vi1[i + 1] - Vi1[i]) * (($abstime - T1[i]) / (T1[i + 1] - T1[i]));
        end
      end
      if ($abstime >= T1[size - 3]) begin V_wr = Vi1[size - 3]; end

	// Linear interpolation for Vwg1
      for (i = 0; i < size - 5; i = i + 1) begin
        if ($abstime >= T1[i] && $abstime < T1[i + 1]) begin
          V_wg1 = Vi2[i] + (Vi2[i + 1] - Vi2[i]) * (($abstime - T1[i]) / (T1[i + 1] - T1[i]));
        end
      end

     // Linear interpolation for Vwg1
      for (i = 0; i < size - 2; i = i + 1) begin
        if ($abstime >= T2[i] && $abstime < T2[i + 1]) begin
          V_wg = Vi3[i] + (Vi3[i + 1] - Vi3[i]) * (($abstime - T2[i]) / (T2[i + 1] - T2[i]));
        end
      end
      if ($abstime >= T2[size - 2]) begin  V_wg = Vi3[size - 2]; end

      // Linear interpolation for Vwl
      for (i = 0; i < size - 1; i = i + 1) begin
        if ($abstime >= T1[i] && $abstime < T1[i + 1]) begin
          V_wl1 = Vi4[i] + (Vi4[i + 1] - Vi4[i]) * (($abstime - T1[i]) / (T1[i + 1] - T1[i]));
        end
      end
      if ($abstime >= T1[size - 1]) begin V_wl = Vi4[size - 1]; end

      // Linear interpolation for Vwl1
      for (i = 0; i < size - 1; i = i + 1) begin
        if ($abstime >= T1[i] && $abstime < T1[i + 1]) begin
          V_wl = Vi5[i] + (Vi5[i + 1] - Vi5[i]) * (($abstime - T1[i]) / (T1[i + 1] - T1[i]));
        end
      end
      if ($abstime >= T1[size - 1]) begin  V_wl1 = Vi5[size - 1]; end

	// Linear interpolation for Vs
      for (i = 0; i < size - 5; i = i + 1) begin
        if ($abstime >= T1[i] && $abstime < T1[i + 1]) begin
          V_sl1 = Vi6[i] + (Vi6[i + 1] - Vi6[i]) * (($abstime - T1[i]) / (T1[i + 1] - T1[i]));
        end
      end

     // Linear interpolation for Vsl1
      for (i = 0; i < size - 2; i = i + 1) begin
        if ($abstime >= T2[i] && $abstime < T2[i + 1]) begin
          V_sl = Vi7[i] + (Vi7[i + 1] - Vi7[i]) * (($abstime - T2[i]) / (T2[i + 1] - T2[i]));
        end
      end
      // Hold the voltage after the last time point
      if ($abstime >= T2[size - 2]) begin V_sl = Vi7[size - 2]; end
      if ($abstime >= T1[1])
		 begin  V_wg1 = Vi2[1];
				V_sl1 = Vi6[1];
		 end

      // Apply the calculated voltage to the terminals p and n
      V(p[0], n[0]) <+ V_s;
      V(p[1], n[1]) <+ V_wr;
      V(p[2], n[2]) <+ V_wg;
      V(p[3], n[3]) <+ V_wg1;
      V(p[4], n[4]) <+ V_wl;
      V(p[5], n[5]) <+ V_wl1;
      V(p[6], n[6]) <+ V_sl;
      V(p[7], n[7]) <+ V_sl1;
    end

	 // Output the same voltage to the output node
      V(Vs) <+  V(p[0], n[0]);
      V(Vwr) <+  V(p[1], n[1]);
      V(Vwg) <+  V(p[2], n[2]);
      V(Vwg1) <+  V(p[3], n[3]);
      V(Vwl) <+  V(p[4], n[4]);
      V(Vwl1) <+  V(p[5], n[5]);
      V(Vsl) <+  V(p[6], n[6]);
      V(Vsl1) <+  V(p[7], n[7]);
  end
endmodule

module Test(data, Vwr_1, Vwl_1, Vs_1 , Vwl1_1, Vwg_1, Vwg1_1, Vsl_1, Vsl1_1);

input data[0:7];
output Vwr_1[0:7], Vwl_1[0:7], Vs_1[0:7] , Vwl1_1[0:7], Vwg_1[0:7], Vwg1_1[0:7], Vsl_1[0:7], Vsl1_1[0:7];

pwl u0(.in(data[0]),.Vwr(Vwr_1[0]),.Vwl(Vwl_1[0]), .Vs(Vs_1[0]) , .Vwl1(Vwl1_1[0]), .Vwg(Vwg_1[0]), Vwg1(Vwg1_1[0]), .Vsl(Vsl_1[0]), .Vsl1(Vsl1_1[0]));

endmodule
