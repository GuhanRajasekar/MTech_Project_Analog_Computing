// VerilogA for VerilogA, Data_read1, veriloga

`include "constants.vams"
`include "disciplines.vams"

module Data_read_a15( VDDI, D_p0, D_p1, D_p2, D_p3, D_p4, D_p5, D_p6, D_p7,D_n0, D_n1, D_n2, D_n3, D_n4, D_n5, D_n6, D_n7 );
    input VDDI;         //Power signal
    electrical VDDI;    // Declaring power signal as electrical signal

    //D_p0 and D_n0 store the 1st bit from the right(LSB) of each weight entry in the text file
    //D_p1 and D_n1 store the 2nd bit from the right      of each weight entry in the text file
    //D_p2 and D_n2 store the 3rd bit from the right      of each weight entry in the text file
    //D_p3 and D_n3 store the 4th bit from the right      of each weight entry in the text file
    //D_p4 and D_n4 store the 5th bit from the right      of each weight entry in the text file
    //D_p5 and D_n5 store the 6th bit from the right      of each weight entry in the text file
    //D_p6 and D_n6 store the 7th bit from the right      of each weight entry in the text file
    //D_p7 and D_n7 store the 8th bit from the right(MSB) of each weight entry in the text file

    output [19:0] D_p0, D_p1, D_p2, D_p3, D_p4, D_p5, D_p6, D_p7 ;       //Upper index = [Total number of weights for a single neuron - 1]
    output [19:0] D_n0, D_n1, D_n2, D_n3, D_n4, D_n5, D_n6, D_n7 ;       //Upper index = [Total number of weights for a single neuron - 1]
    electrical [19:0] D_p0, D_p1, D_p2, D_p3, D_p4, D_p5, D_p6, D_p7 ;   //Upper index = [Total number of weights for a single neuron - 1]
    electrical [19:0] D_n0, D_n1, D_n2, D_n3, D_n4, D_n5, D_n6, D_n7 ;   //Upper index = [Total number of weights for a single neuron - 1]

    // integer data type can store 32 bits in Verilog-A
    integer file, status;
    integer binary_data_array[0:399];    // Second index = [Total number of weights present in the text file - 1]
    integer binary_data;                 // Single integer capable of storing 32 bits of data. Each line will be read from the text file and will be stored in this variable
    integer is_file_open;                // flag to indicate if the text file exists or not
    integer j;                           // This variable is used to index binary_data_array[]
    genvar  i, index;                    // these variables are used for indexing purposes

  analog begin

	if (V(VDDI)>1)
       begin

        for (index = 0; index <= 399; index = index + 1)  // Upper limit for index in the for loop = [Total number of weights present in the text file - 1]
           begin
             // Initially, we fill the array with multiple entries of 32 bit zeros (A 32 bit string of 0s can be considered as one entry. 32 because integer size is 32 in Verilog-A).
             // There will be multiple rows in binary_data_array and each row will have 32 bits of zeros.
             // Number of rows in binary_data_array is equal to the number of weights present in the text file
             binary_data_array[index] = 0;
           end

         // Open the file in read mode
        file = $fopen("/home/guhanr/worklib_sky/Layer1_weights/layer1_weights_final.txt", "r");
      	if (file == 0)
          begin
        		 $strobe("Error: Could not open file data.txt.");
       		 is_file_open = 0; // Set the flag to indicate failure
      	  end

        else
          begin
        		is_file_open = 1; // Set the flag to indicate success (file can be opened for reading)
     	 end

      	if (is_file_open)
          begin
        		index = 0;
       		while (!$feof(file) && index <= 399) // The upper limit for index = [Total number of weights present in the text file - 1]
                begin
                   /*
                       Now, we begin reading the text file line by line. Each line of the text file will have an 8 bit weight value. Each 8 bit value is stored in the integer variable "binary_data".
                       This 32 bit value is then transferred to the variable " binary_data_array[index] "
                   */

                   status = $fscanf(file, "%b\n", binary_data); // Here the "\n" operator makes sure that one line is read at a time and the file pointer is moved to the next line after finishing one line

          		  if (status > 0)  // status > 0 indicates successful read operation
                        begin
            			     binary_data_array[index] = binary_data;    // Here binary_data and binary_data_array[index] are 32 bit values and the 8 bits from the LSB end hold our required weight value
                          //$strobe("Stored binary_data_array[%0d] = %b", index, binary_data_array[index]);
           			     //$strobe("Stored binary_data_array[%0d] = %b", index, binary_data);
           			     index = index + 1;
         		       end
                  else
                        begin
            	             $strobe("Error reading binary data");
           	             break;
                        end
        		   end  // while loop
             $fclose(file);
             $strobe("Finished reading data.");
      	 end   // if(is_file_open)

/* By the end of hte above while loop, all the entries in the text file will be transferred to the array  named "binary_data_array" */

// Value of "j" for the neuron "ai" = [i-1] * 20
// Value of "j" for the neuron "a15" = [15-1] * 20 = 280
    j = 280;

	for (i = 0; i <= 19; i= i + 1)   // Upper index for i = [Total number of weights for a single neuron - 1]
      begin
            // Here binary_data_array[i] is a 32 bit value. Of the 32 bits, 8 bits from the LSB is our required weight value
            // We first check the MSB of the "i th" weight to determine whether the weight value must be stored in the postive part or the negative part

             if (	((binary_data_array[j] >> 7) & 1) ==1)  // MSB of the "i th" weight is 1. Hence all bits of the "i th" weight must be stored in D_n0, D_n1, D_n2, D_n3, D_n4, D_n5, D_n6, D_n7
                  begin
                       V(D_p0[i]) <+ 0 ; // 0 to D_p0[i] as MSB of the "i th" weight is 1
					  V(D_p1[i]) <+ 0 ; // 0 to D_p1[i] as MSB of the "i th"  weight is 1
					  V(D_p2[i]) <+ 0 ; // 0 to D_p2[i] as MSB of the "i th"  weight is 1
					  V(D_p3[i]) <+ 0 ; // 0 to D_p3[i] as MSB of the "i th"  weight is 1
					  V(D_p4[i]) <+ 0 ; // 0 to D_p4[i] as MSB of the "i th"  weight is 1
					  V(D_p5[i]) <+ 0 ; // 0 to D_p5[i] as MSB of the "i th"  weight is 1
				      V(D_p6[i]) <+ 0 ; // 0 to D_p6[i] as MSB of the "i th"  weight is 1
					  V(D_p7[i]) <+ 0 ; // 0 to D_p7[i] as MSB of the "i th"  weight is 1

            			  V(D_n0[i]) <+ (binary_data_array[j] >> 0) & 1; // Store 1st bit from the right(LSB) of the "i th" weight in D_n0[i] as MSB of the "i th" weight is 1
            			  V(D_n1[i]) <+ (binary_data_array[j] >> 1) & 1; // Store 2nd bit from the right      of the "i th" weight in D_n0[i] as MSB of the "i th" weight is 1
            			  V(D_n2[i]) <+ (binary_data_array[j] >> 2) & 1; // Store 3rd bit from the right      of the "i th" weight in D_n0[i] as MSB of the "i th" weight is 1
            			  V(D_n3[i]) <+ (binary_data_array[j] >> 3) & 1; // Store 4th bit from the right      of the "i th" weight in D_n0[i] as MSB of the "i th" weight is 1
            			  V(D_n4[i]) <+ (binary_data_array[j] >> 4) & 1; // Store 5th bit from the right      of the "i th" weight in D_n0[i] as MSB of the "i th" weight is 1
            			  V(D_n5[i]) <+ (binary_data_array[j] >> 5) & 1; // Store 6th bit from the right      of the "i th" weight in D_n0[i] as MSB of the "i th" weight is 1
            			  V(D_n6[i]) <+ (binary_data_array[j] >> 6) & 1; // Store 7th bit from the right      of the "i th" weight in D_n0[i] as MSB of the "i th" weight is 1
            			  V(D_n7[i]) <+ (binary_data_array[j] >> 7) & 1; // Store 8th bit from the right(MSB) of the "i th" weight in D_n0[i] as MSB of the "i th" weight is 1

             // $strobe("Stored binary_data_array_P[%0d] = %b%b%b%b%b%b%b%b", ibdex, binary_data);  // Printing the data for debugging purposes
			// $strobe("Stored binary_data_array_N[%0d] = %b%b%b%b%b%b%b%b", i, binary_data);          // Printing the data for debugging purposes
                       j=j+1;

                  end

            else   // MSB of the "i th" weight is 0. Hence all bits of the "i th" weight must be stored in D_p0, D_p1, D_p2, D_p3, D_p4, D_p5, D_p6, D_p7
                 begin
					  V(D_n0[i]) <+ 0 ; // 0 to D_n0[i] as MSB of the "i th" weight is 0
				   	  V(D_n1[i]) <+ 0 ; // 0 to D_n1[i] as MSB of the "i th" weight is 0
					  V(D_n2[i]) <+ 0 ; // 0 to D_n2[i] as MSB of the "i th" weight is 0
					  V(D_n3[i]) <+ 0 ; // 0 to D_n3[i] as MSB of the "i th" weight is 0
					  V(D_n4[i]) <+ 0 ; // 0 to D_n4[i] as MSB of the "i th" weight is 0
					  V(D_n5[i]) <+ 0 ; // 0 to D_n5[i] as MSB of the "i th" weight is 0
					  V(D_n6[i]) <+ 0 ; // 0 to D_n6[i] as MSB of the "i th" weight is 0
					  V(D_n7[i]) <+ 0 ; // 0 to D_n7[i] as MSB of the "i th" weight is 0

            			  V(D_p0[i]) <+ (binary_data_array[j] >> 0) & 1; // Store 1st bit from the right(LSB) of the "i th" weight in D_p0[i] as MSB of the "i th" weight is 0
            			  V(D_p1[i]) <+ (binary_data_array[j] >> 1) & 1; // Store 2nd bit from the right      of the "i th" weight in D_p0[i] as MSB of the "i th" weight is 0
            			  V(D_p2[i]) <+ (binary_data_array[j] >> 2) & 1; // Store 3rd bit from the right      of the "i th" weight in D_p0[i] as MSB of the "i th" weight is 0
            			  V(D_p3[i]) <+ (binary_data_array[j] >> 3) & 1; // Store 4th bit from the right      of the "i th" weight in D_p0[i] as MSB of the "i th" weight is 0
            			  V(D_p4[i]) <+ (binary_data_array[j] >> 4) & 1; // Store 5th bit from the right      of the "i th" weight in D_p0[i] as MSB of the "i th" weight is 0
            			  V(D_p5[i]) <+ (binary_data_array[j] >> 5) & 1; // Store 6th bit from the right      of the "i th" weight in D_p0[i] as MSB of the "i th" weight is 0
            			  V(D_p6[i]) <+ (binary_data_array[j] >> 6) & 1; // Store 7th bit from the right      of the "i th" weight in D_p0[i] as MSB of the "i th" weight is 0
            			  V(D_p7[i]) <+ (binary_data_array[j] >> 7) & 1; // Store 8th bit from the right(MSB) of the "i th" weight in D_p0[i] as MSB of the "i th" weight is 0

                       j = j+1;

				end

		//		end
			end    // 	for (i = 0; i < 8; i= i + 1)

	end            // if (V(VDDI)>1)

end                // analog begin

endmodule
